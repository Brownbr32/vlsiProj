// Design: lab1_bb/inverter_tb
simulator lang=spectre
global 0 vdda!
parameters Vin=1
include "/usr/local/cad_common/local/setups/GPDK/gpdk045_v_6_0/gpdk045/../models/spectre/gpdk045.scs" section=mc

// lab1_bb/inverter/schematic
subckt inverter _net1 _net0
    NM0 (_net0 _net1 0 0) g45n1svt w=(120n) l=45n nf=1 m=(1)
    PM0 (_net0 _net1 vdda! vdda!) g45p1svt w=(120n) l=45n nf=1 m=(1)
ends inverter

// lab1_bb/inverter_tb/schematic
V0 (_net0 0) vsource dc=Vin type=pulse val0=0 val1=1 period=20n rise=10p fall=10p width=10n
I4 (_net0 out\-put) inverter
V1 (vdda! 0) vsource dc=1 type=dc
simulatorOptions options temp=27
dc dc param=Vin start=0 stop=1 step=10m
tran tran stop=100n errpreset=conservative
